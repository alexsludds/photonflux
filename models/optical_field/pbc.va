`include "discipline.h"
`include "constants.h"

// Polarization beam combiner (PBC) for dual-polarization coherent fields.
//
// The reciprocal twin of pbs.va: two Jones inputs, one Jones output. The TE
// (X) component is taken from port 1 and the TM (Y) component from port 2 and
// they are multiplexed onto one net:
//
//   Ex_out = tx*Ex_in1 + lk*Ex_in2
//   Ey_out = lk*Ey_in1 + tx*Ey_in2
//
// er_db sets the finite extinction (lk = 10^(-er_db/20), tx = sqrt(1-lk^2));
// er_db -> inf gives the ideal combiner Ex_out = Ex_in1, Ey_out = Ey_in2.
// s = 10^(-il_db/20) is a common excess loss. Feeding a PBS's two outputs
// straight into a PBC reconstructs the original Jones vector (unit throughput
// in the ideal limit).
//
// Dual-pol convention: Jones vector as two Ereal/Eimag node pairs, X = TE,
// Y = TM, |Ex|^2 + |Ey|^2 = power [W]. Inputs at infinite impedance; output
// driven — never tie two driven outputs to the same node.
module pbc(i1x_re, i1x_im, i1y_re, i1y_im,
           i2x_re, i2x_im, i2y_re, i2y_im,
           ox_re, ox_im, oy_re, oy_im, gnd);
    inout i1x_re, i1x_im, i1y_re, i1y_im,
          i2x_re, i2x_im, i2y_re, i2y_im,
          ox_re, ox_im, oy_re, oy_im, gnd;
    electrical i1x_re, i1x_im, i1y_re, i1y_im,
               i2x_re, i2x_im, i2y_re, i2y_im,
               ox_re, ox_im, oy_re, oy_im, gnd;

    // reactive dummy (see mirror.va).
    electrical dmy;

    parameter real er_db  = 300.0 from (0:inf);  // polarization extinction [dB]
    parameter real il_db  = 0.0   from [0:inf);  // common insertion loss [dB]

    real s, lk, tx;

    analog begin
        I(dmy, gnd) <+ 1e-12 * ddt(V(dmy, gnd)) + V(dmy, gnd);

        s  = pow(10.0, -il_db / 20.0);
        lk = pow(10.0, -er_db / 20.0);
        tx = s * sqrt(1.0 - lk * lk);
        lk = s * lk;

        // X from port 1 (+ leakage from port 2)
        V(ox_re, gnd) <+ tx * V(i1x_re, gnd) + lk * V(i2x_re, gnd);
        V(ox_im, gnd) <+ tx * V(i1x_im, gnd) + lk * V(i2x_im, gnd);
        // Y from port 2 (+ leakage from port 1)
        V(oy_re, gnd) <+ lk * V(i1y_re, gnd) + tx * V(i2y_re, gnd);
        V(oy_im, gnd) <+ lk * V(i1y_im, gnd) + tx * V(i2y_im, gnd);
    end
endmodule
