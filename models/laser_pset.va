`include "discipline.h"
`include "constants.h"

// CW laser specified by *desired output power*, not an electrical drive.
//   Input  `pset` (referenced to gnd): voltage = desired optical power [W].
//   Output `popt` (referenced to gnd): voltage = optical power [W].
//
// A flat power source for external-modulation links: hold pset at the wanted
// carrier power (e.g. a 12 mV source -> 12 mW) and popt tracks it through a
// first-order turn-on/settling response (tau). Output is clamped >= 0.
module laser_pset(pset, gnd, popt);
    inout pset, gnd, popt;
    electrical pset, gnd, popt;

    parameter real tau = 50p from [0:inf);   // optical response time constant [s]

    real ptgt;

    analog begin
        ptgt = V(pset, gnd);
        if (ptgt < 0.0) ptgt = 0.0;
        V(popt, gnd) <+ ptgt - tau * ddt(V(popt, gnd));
    end
endmodule
