`include "discipline.h"
`include "constants.h"

// Directly-modulated laser from the standard single-mode rate equations.
// Captures what the static laser_dml cannot: turn-on delay, relaxation
// oscillations, and pattern-dependent ringing in the optical eye.
//
//   dN/dt = eta_i*I/(q*Va) - N/tau_n - vg*a0*(N - Ntr)*S/(1 + eps*S)
//   dS/dt = Gam*vg*a0*(N - Ntr)*S/(1 + eps*S) - S/tau_p
//           + Gam*beta*N/tau_n
//   P     = eta0 * (Va*Eph/(Gam*tau_p)) * S / 2        (per facet)
//
// State variables live on internal nodes, normalised to keep the solver
// well conditioned:  V(nn) = N/Nscl,  V(ns) = S/Sscl.
//
// Electrical port (an, cat): linearised diode (Von, Rs), same as laser_dml.
// Optical output `popt` (vs gnd): node voltage = optical power [W].
//
// Defaults are a generic 1.31 um in-plane DFB (Coldren-style numbers):
// Ith ~ 19 mA, fr ~ 6 GHz at ~2x threshold.
module laser_rate(an, cat, popt, gnd);
    inout an, cat, popt, gnd;
    electrical an, cat, popt, gnd;
    electrical nn, ns;     // internal: normalised carrier / photon densities

    parameter real Rs    = 5.0    from (0:inf);  // series resistance [ohm]
    parameter real Von   = 1.2;                  // turn-on voltage [V]
    parameter real etai  = 0.8    from (0:1];    // injection efficiency
    parameter real eta0  = 0.4    from (0:1];    // optical (differential) efficiency
    parameter real Va    = 1e-16  from (0:inf);  // active volume [m^3]
    parameter real Ntr   = 1e24   from (0:inf);  // transparency density [m^-3]
    parameter real a0    = 2.5e-20 from (0:inf); // differential gain [m^2]
    parameter real vg    = 7.5e7  from (0:inf);  // group velocity [m/s]
    parameter real taun  = 2n     from (0:inf);  // carrier lifetime [s]
    parameter real taup  = 2p     from (0:inf);  // photon lifetime [s]
    parameter real Gam   = 0.3    from (0:1];    // confinement factor
    parameter real beta  = 1e-4   from (0:1];    // spontaneous-emission factor
    parameter real eps   = 1.5e-23 from [0:inf); // gain compression [m^3]
    parameter real Eph   = 1.516e-19 from (0:inf); // photon energy [J] (1.31 um)

    // normalisation: carrier/photon densities in units of Nscl/Sscl
    localparam real Nscl = 1e24;
    localparam real Sscl = 1e21;
    localparam real Csc  = 1e-12;   // node "capacitance" scaling [F]

    real Idrv, N, S, Seff, gain, rhsN, rhsS;

    analog begin
        // ---- electrical port: linearised diode ------------------------
        Idrv = (V(an, cat) - Von) / Rs;
        if (Idrv < 0.0) Idrv = 0.0;
        I(an, cat) <+ Idrv;

        // ---- rate equations on internal nodes -------------------------
        N = V(nn, gnd) * Nscl;
        S = V(ns, gnd) * Sscl;
        // Positivity guard: with raw S the DC system has a spurious
        // stationary branch at S < 0 that Newton can land on above
        // threshold. Using max(S,0) in the stimulated terms leaves
        // -S/taup + spontaneous pumping as the only restoring terms for
        // S < 0, which has no root there -- the lasing branch is the
        // unique DC solution.
        Seff = (S > 0.0) ? S : 0.0;
        gain = vg * a0 * (N - Ntr) / (1.0 + eps * Seff);

        rhsN = etai * Idrv / (`P_Q * Va) - N / taun - gain * Seff;
        rhsS = Gam * gain * Seff - S / taup + Gam * beta * N / taun;

        // dV/dt = rhs/scale  enforced via scaled charge + matching current
        I(nn, gnd) <+ Csc * ddt(V(nn, gnd)) - Csc * rhsN / Nscl;
        I(ns, gnd) <+ Csc * ddt(V(ns, gnd)) - Csc * rhsS / Sscl;

        // ---- optical output -------------------------------------------
        V(popt, gnd) <+ 0.5 * eta0 * (Va * Eph / (Gam * taup)) * S;
    end
endmodule
