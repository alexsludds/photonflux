`include "discipline.h"
`include "constants.h"

`define P_C0 2.99792458e8   // speed of light [m/s]

// Carrier-INJECTION silicon microring modulator (all-pass, forward-biased
// PIN phase shifter) — the injection twin of ring_mod.va's depletion device.
//
// Same single-mode CMT core (see ring_mod.va), but the resonance is tuned by
// the injected free-carrier population instead of the depletion width:
//
//   * the electrical port is a forward diode (linearised: Von, Rs), and the
//     carrier population responds with the recombination lifetime tau_c —
//     modelled as i_eq, a first-order low-pass of the injected current:
//         tau_c * d(i_eq)/dt = I_drive - i_eq
//     This is what limits injection rings to ~1/(2*pi*tau_c) modulation
//     bandwidth unless they are driven with pre-emphasis.
//   * free-carrier dispersion BLUE-shifts the resonance:
//         lambda_res = lambda_res_nm - dl_di_pm_ma * i_eq[mA]   (dl > 0)
//   * free-carrier absorption adds propagation loss:
//         loss = loss_db_m + fca_db_m_ma * i_eq[mA]
//
// Coherent-field convention: optical ports are Ereal/Eimag node pairs with
// |E|^2 = power [W]; internal state A = kappa*a, rows scaled by tau (same
// idiom as ring_mod.va). The carrier row is scaled by tau_c and carries
// i_eq in mA so all unknowns stay O(1).
module ring_mod_inj(in_re, in_im, out_re, out_im, vp, vn, gnd);
    inout in_re, in_im, out_re, out_im, vp, vn, gnd;
    electrical in_re, in_im, out_re, out_im, vp, vn, gnd;

    electrical are, aim;   // intracavity field A = kappa*a [sqrt(W)]
    electrical ni;         // i_eq [mA]: lifetime-filtered injection current

    parameter real lambda_nm     = 1310.0 from (0:inf);  // laser wavelength [nm]
    parameter real lambda_res_nm = 1310.0 from (0:inf);  // aligned resonance [nm]
    parameter real radius_um     = 7.5    from (0:inf);  // ring radius [um]
    parameter real n_g           = 4.0    from (0:inf);  // group index
    parameter real loss_db_m     = 3000.0 from (0:inf);  // passive loss [dB/m]
    parameter real kappa2        = 0.05   from (0:1);    // bus power coupling
    parameter real tau_c         = 1n     from (0:inf);  // carrier lifetime [s]
    parameter real dl_di_pm_ma   = 50.0   from [0:inf);  // blue shift [pm/mA]
    parameter real fca_db_m_ma   = 400.0  from [0:inf);  // FCA loss [dB/m/mA]
    parameter real Von           = 0.9;                  // diode turn-on [V]
    parameter real Rs            = 50.0   from (0:inf);  // series resistance [ohm]
    parameter real cj_ff_um      = 1.0    from [0:inf);  // junction cap [fF/um]

    real circ, v_g, t_rt, alpha_m, loss_eff;
    real inv_tau_i0, inv_tau_e, inv_tau, tau0, tk2, cj;
    real lam_res_eff, delta, idrv, ieq_ma, ieq_pos;

    analog begin
        // ---- electrical port: forward-biased injection diode ----------
        idrv = (V(vp, vn) - Von) / Rs;
        if (idrv < 0.0) idrv = 0.0;
        cj = cj_ff_um * 1e-15 * radius_um * 2.0 * `M_PI;
        I(vp, vn) <+ idrv + cj * ddt(V(vp, vn));

        // ---- carrier population: lifetime-filtered current [mA] --------
        ieq_ma = V(ni, gnd);
        I(ni, gnd) <+ tau_c * ddt(V(ni, gnd)) + V(ni, gnd) - idrv * 1e3;

        // ---- carrier-dependent CMT rates -------------------------------
        // Rows are scaled by the CONSTANT zero-injection tau0 (a state-
        // dependent coefficient on ddt() breaks the bosdi lowering); the
        // carrier-dependent decay 1/tau shows up in the resistive terms.
        ieq_pos    = (ieq_ma > 0.0) ? ieq_ma : 0.0;
        circ       = 2.0 * `M_PI * radius_um * 1e-6;
        v_g        = `P_C0 / n_g;
        t_rt       = circ / v_g;
        inv_tau_i0 = loss_db_m * ln(10.0) / 10.0 * v_g / 2.0;
        inv_tau_e  = kappa2 / (2.0 * t_rt);
        tau0       = 1.0 / (inv_tau_i0 + inv_tau_e);
        loss_eff   = loss_db_m + fca_db_m_ma * ieq_pos;
        alpha_m    = loss_eff * ln(10.0) / 10.0;
        inv_tau    = alpha_m * v_g / 2.0 + inv_tau_e;
        tk2        = tau0 * 2.0 * inv_tau_e;

        // free-carrier dispersion: injection BLUE-shifts the resonance
        lam_res_eff = lambda_res_nm * 1e-9 - dl_di_pm_ma * 1e-12 * ieq_pos;
        delta = 2.0 * `M_PI * `P_C0 * (1.0 / (lambda_nm * 1e-9) - 1.0 / lam_res_eff);

        // ---- CMT rate equations (rows scaled by constant tau0) ----------
        I(are, gnd) <+ tau0 * ddt(V(are, gnd)) + tau0 * inv_tau * V(are, gnd)
                       - tau0 * delta * V(aim, gnd) + tk2 * V(in_im, gnd);
        I(aim, gnd) <+ tau0 * ddt(V(aim, gnd)) + tau0 * inv_tau * V(aim, gnd)
                       + tau0 * delta * V(are, gnd) - tk2 * V(in_re, gnd);

        // through port: s_out = s_in + j*A
        V(out_re, gnd) <+ V(in_re, gnd) - V(aim, gnd);
        V(out_im, gnd) <+ V(in_im, gnd) + V(are, gnd);
    end
endmodule
