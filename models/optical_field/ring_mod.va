`include "discipline.h"
`include "constants.h"

`define P_C0 2.99792458e8   // speed of light [m/s]

// Silicon photonic microring modulator (all-pass, depletion phase shifter),
// parameterised by the physical device: ring radius, group/effective index,
// PN-junction propagation loss, bus power coupling, junction capacitance per
// unit length, and the electro-optic detuning rate.
//
// Hierarchical model: the ring is assembled from its three coherent-field
// CMT sub-components, joined on one internal cavity node (are, aim) — the
// circulating field A = kappa*a in sqrt(W):
//
//     directional_coupler.va — bus<->ring point coupler + through-port tap
//                              (external rate 1/tau_e)
//     ring_phase_shifter.va  — intracavity EO detuning delta(V) + the
//                              junction load the driver sees
//     ring_waveguide.va      — the ring waveguide loop: photon storage
//                              (dA/dt) + round-trip loss (rate 1/tau_i)
//
// Kirchhoff's sum on the cavity node reproduces the single-mode
// coupled-mode-theory ODE (Little/Manolatou) of the old monolithic model
// exactly (machine precision, tests/test_ring_decomposition.py):
//
//     da/dt = (-j*delta - 1/tau) a + j*kappa*s_in ,   s_out = s_in + j*kappa*a
//
// (engineering convention e^{+j*w*t}, delta = w_laser - w_res)
//
// with the decay rates derived from the device below. This mirrors the
// Python-level decomposition (cx.ring_modulator, ALE-52); the sub-components
// are ordinary standalone models too. NB the VA->JAX lowering has no
// structural hierarchy of its own (openvaf drops child instances), so
// cx.va() flattens this file source-level before compiling — see
// photonflux/va_hier.py for the supported hierarchy subset.
//
//     L      = 2*pi*radius                    round-trip length
//     T_rt   = L * n_g / c                    round-trip time
//     alpha  = loss_db_m * ln(10)/10          power attenuation [1/m]
//     1/tau_i = alpha * v_g / 2               intrinsic (junction loss)
//     1/tau_e = kappa2 / (2*T_rt)             coupling (bus, power coupling kappa2)
//     kappa^2 = 2/tau_e
//
// Steady state through-port transmission is the Lorentzian
//
//     |H|^2 = ((1 - tau*kappa^2)^2 + (tau*delta)^2) / (1 + (tau*delta)^2)
//
// critically coupled (perfect null) when kappa2 = alpha*L; over/under-coupled
// dips bottom out at ((1 - tau*kappa^2))^2. Being an ODE, the model also
// captures the photon-lifetime-limited modulation bandwidth f_opt/Q_loaded.
//
// Resonance alignment: real rings carry a thermal tuner, so the model assumes
// the operating resonance is aligned to `lambda_res_nm` (the effective index
// only fixes which cold mode m = n_eff*L/lambda gets pulled onto the grid —
// it does not enter the aligned single-mode dynamics). The depletion phase
// shifter then moves it linearly: lambda_res(V) = lambda_res_nm + dl_dv_pm*V.
//
// Coherent-field convention: optical ports are Ereal/Eimag node pairs with
// |E|^2 = optical power [W] (same normalisation as the circulax field nodes).
module ring_mod(in_re, in_im, out_re, out_im, vp, vn, gnd);
    inout in_re, in_im, out_re, out_im, vp, vn, gnd;
    electrical in_re, in_im, out_re, out_im, vp, vn, gnd;

    // shared cavity node: intracavity field A = kappa*a (Are, Aim in sqrt(W))
    electrical are, aim;

    parameter real lambda_nm     = 1310.0 from (0:inf);  // laser wavelength [nm]
    parameter real lambda_res_nm = 1310.0 from (0:inf);  // aligned resonance [nm]
    parameter real radius_um     = 7.5    from (0:inf);  // ring radius [um]
    parameter real n_g           = 4.0    from (0:inf);  // group index
    parameter real n_eff         = 2.4    from (0:inf);  // effective index (mode order)
    parameter real loss_db_m     = 7000.0 from (0:inf);  // junction propagation loss [dB/m]
    parameter real kappa2        = 0.10   from (0:1);    // bus power coupling |kappa|^2
    parameter real dl_dv_pm      = 45.0;                 // resonance shift [pm/V]
    parameter real cj_ff_um      = 0.5    from [0:inf);  // junction cap [fF/um]
    parameter real rleak         = 1e8    from (0:inf);  // junction leakage [ohm]

    // device geometry -> CMT decay rates (constant expressions of the
    // parameters, so they are legal in the instance overrides below)
    localparam real circ      = 2.0 * `M_PI * radius_um * 1e-6;      // [m]
    localparam real v_g       = `P_C0 / n_g;
    localparam real t_rt      = circ / v_g;
    localparam real alpha_m   = loss_db_m * `M_LN10 / 10.0;          // power attenuation [1/m]
    localparam real inv_tau_i = alpha_m * v_g / 2.0;                 // amplitude decay, loss
    localparam real inv_tau_e = kappa2 / (2.0 * t_rt);               // amplitude decay, coupling
    localparam real cj        = cj_ff_um * 1e-15 * radius_um * 2.0 * `M_PI;  // [F]

    // bus<->ring coupler: couples s_in into the cavity, taps the through port
    directional_coupler #(.inv_tau_e(inv_tau_e))
        cpl(.in_re(in_re), .in_im(in_im), .out_re(out_re), .out_im(out_im),
            .are(are), .aim(aim), .gnd(gnd));

    // intracavity depletion phase shifter: EO detuning + junction load
    ring_phase_shifter #(.lambda_nm(lambda_nm), .lambda_res_nm(lambda_res_nm),
                         .dl_dv_pm(dl_dv_pm), .cj(cj), .rleak(rleak))
        ps(.are(are), .aim(aim), .vp(vp), .vn(vn), .gnd(gnd));

    // ring waveguide loop: photon storage + round-trip loss
    ring_waveguide #(.inv_tau_i(inv_tau_i))
        wg(.are(are), .aim(aim), .gnd(gnd));
endmodule
