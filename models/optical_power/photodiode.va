`include "discipline.h"
`include "constants.h"

// PIN photodiode: linear responsivity model.
//   Optical input `popt` (referenced to gnd): voltage represents optical power [W].
//   Electrical port (an, cat): the photocurrent is a reverse current — it
//   flows through the diode from cathode to anode and leaves at the anode
//   (an unbiased diode's anode charges positive; a reverse-biased one sources
//   Iph out of the anode into a TIA). Same polarity as the webapp/example
//   coherent-field photodiodes.
//   `Cj` adds junction capacitance for small-signal bandwidth.
module photodiode(popt, gnd, an, cat);
    inout popt, gnd, an, cat;
    electrical popt, gnd, an, cat;

    parameter real R    = 0.8   from (0:inf);   // responsivity [A/W]
    parameter real Idk  = 1n    from [0:inf);   // dark current [A]
    parameter real Cj   = 100f  from [0:inf);   // junction capacitance [F]

    real Iph;

    analog begin
        Iph = R * V(popt, gnd) + Idk;
        I(cat, an) <+ Iph;
        I(an, cat) <+ Cj * ddt(V(an, cat));
    end
endmodule
